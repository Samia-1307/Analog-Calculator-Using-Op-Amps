* D:\OneDrive - BUET\Desktop\Project demo\DC\DC_exponential.sch

* Schematics Version 9.2
* Wed Sep 13 05:23:27 2023

** Analysis setup **
.tran 0.1 10
.OP

* From [PSPICE NETLIST] section of C:\Program Files\Orcad\PSpice\PSpice.ini:
.lib "nom.lib"

.INC "DC_exponential.net"

.PROBE V(*) I(*) W(*) D(*) NOISE(*)

.END
