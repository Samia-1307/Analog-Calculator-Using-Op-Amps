* D:\OneDrive - BUET\Desktop\Project demo\DC\DC_integration.sch

* Schematics Version 9.2
* Sat Sep 16 18:52:12 2023

** Analysis setup **
.tran 0.01m 5m 0 0.01m
.TEMP 25
.OP

* From [PSPICE NETLIST] section of C:\Program Files\Orcad\PSpice\PSpice.ini:
.lib "nom.lib"

.INC "DC_integration.net"

.PROBE V(*) I(*) W(*) D(*) NOISE(*)

.END
