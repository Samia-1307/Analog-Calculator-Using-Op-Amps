* D:\OneDrive - BUET\Desktop\Project demo\DC\DC_root.sch

* Schematics Version 9.2
* Sat Sep 16 20:53:23 2023

** Analysis setup **
.tran 0.1 10
.OP

* From [PSPICE NETLIST] section of C:\Program Files\Orcad\PSpice\PSpice.ini:
.lib "nom.lib"

.INC "DC_root.net"

.PROBE V(*) I(*) W(*) D(*) NOISE(*)

.END
