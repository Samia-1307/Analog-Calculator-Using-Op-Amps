* D:\OneDrive - BUET\Desktop\Project demo\DC\DC_subtraction.sch

* Schematics Version 9.2
* Sat Sep 16 02:22:02 2023

** Analysis setup **
.tran 0.01m 10m 0 0.01m SKIPBP
.TEMP 25
.OP

* From [PSPICE NETLIST] section of C:\Program Files\Orcad\PSpice\PSpice.ini:
.lib "nom.lib"

.INC "DC_subtraction.net"

.PROBE V(*) I(*) W(*) D(*) NOISE(*)

.END
