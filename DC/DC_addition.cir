* D:\OneDrive - BUET\Desktop\Project demo\DC\DC_addition.sch

* Schematics Version 9.2
* Sat Sep 16 01:27:21 2023

** Analysis setup **
.tran 0.1m 10m 0 0.1m SKIPBP
.OP

* From [PSPICE NETLIST] section of C:\Program Files\Orcad\PSpice\PSpice.ini:
.lib "nom.lib"

.INC "DC_addition.net"

.PROBE V(*) I(*) W(*) D(*) NOISE(*)

.END
