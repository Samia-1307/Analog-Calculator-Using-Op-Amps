* D:\OneDrive - BUET\Desktop\Project demo\DC\DC_divider.sch

* Schematics Version 9.2
* Sat Sep 16 03:25:58 2023

** Analysis setup **
.tran 1 1000
.OP

* From [PSPICE NETLIST] section of C:\Program Files\Orcad\PSpice\PSpice.ini:
.lib "nom.lib"

.INC "DC_divider.net"

.PROBE V(*) I(*) W(*) D(*) NOISE(*)

.END
