* D:\OneDrive - BUET\Desktop\Project demo\DC\DC_multiplier.sch

* Schematics Version 9.2
* Sat Sep 16 03:01:11 2023

** Analysis setup **
.tran 1 1000
.OP

* From [PSPICE NETLIST] section of C:\Program Files\Orcad\PSpice\PSpice.ini:
.lib "nom.lib"

.INC "DC_multiplier.net"

.PROBE V(*) I(*) W(*) D(*) NOISE(*)

.END
